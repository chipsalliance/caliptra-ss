// Copyright lowRISC contributors (OpenTitan project).
// Licensed under the Apache License, Version 2.0, see LICENSE for details.
// SPDX-License-Identifier: Apache-2.0
//
// UART register map.

addrmap uart {
    reg {
        name = "Interrupt State Register";
        desc = "Interrupt State Register";

        field {
            desc = "raised if the transmit FIFO is past the high-water mark.";
            sw = r; hw = rw;
        } TX_WATERMARK[0:0] = 1'b1;

        field {
            desc = "raised if the receive FIFO is past the high-water mark.";
            sw = r; hw = rw;
        } RX_WATERMARK[1:1] = 1'b0;

        field {
            desc = "raised if the transmit FIFO has emptied and no transmit is ongoing.";
            sw = rw; hw = rw; onwrite = woclr;
        } TX_DONE[2:2] = 1'b0;

        field {
            desc = "raised if the receive FIFO has overflowed.";
            sw = rw; hw = rw; onwrite = woclr;
        } RX_OVERFLOW[3:3] = 1'b0;

        field {
            desc = "raised if a framing error has been detected on receive.";
            sw = rw; hw = rw; onwrite = woclr;
        } RX_FRAME_ERR[4:4] = 1'b0;

        field {
            desc = "raised if break condition has been detected on receive.";
            sw = rw; hw = rw; onwrite = woclr;
        } RX_BREAK_ERR[5:5] = 1'b0;

        field {
            desc = "raised if RX FIFO has characters remaining in the FIFO without being
            retrieved for the programmed time period.";
            sw = rw; hw = rw; onwrite = woclr;
        } RX_TIMEOUT[6:6] = 1'b0;

        field {
            desc = "raised if the receiver has detected a parity error.";
            sw = rw; hw = rw; onwrite = woclr;
        } RX_PARITY_ERR[7:7] = 1'b0;

        field {
            desc = "raised if the transmit FIFO is empty.";
            sw = r; hw = rw;
        } TX_EMPTY[8:8] = 1'b1;

    } INTR_STATE @ 0x00;

    reg {
        name = "Interrupt Enable Register";
        desc = "Interrupt Enable Register";

        field {
            desc = "Enable interrupt when tx_watermark is set.";
            sw = rw; hw = r;
        } TX_WATERMARK[0:0] = 1'b0;

        field {
            desc = "Enable interrupt when rx_watermark is set.";
            sw = rw; hw = r;
        } RX_WATERMARK[1:1] = 1'b0;

        field {
            desc = "Enable interrupt when tx_done is set.";
            sw = rw; hw = r;
        } TX_DONE[2:2] = 1'b0;

        field {
            desc = "Enable interrupt when rx_overflow is set.";
            sw = rw; hw = r;
        } RX_OVERFLOW[3:3] = 1'b0;

        field {
            desc = "Enable interrupt when rx_frame_err is set.";
            sw = rw; hw = r;
        } RX_FRAME_ERR[4:4] = 1'b0;

        field {
            desc = "Enable interrupt when rx_break_err is set.";
            sw = rw; hw = r;
        } RX_BREAK_ERR[5:5] = 1'b0;

        field {
            desc = "Enable interrupt when rx_timeout is set.";
            sw = rw; hw = r;
        } RX_TIMEOUT[6:6] = 1'b0;

        field {
            desc = "Enable interrupt when rx_parity_err is set.";
            sw = rw; hw = r;
        } RX_PARITY_ERR[7:7] = 1'b0;

        field {
            desc = "Enable interrupt when tx_empty is set.";
            sw = rw; hw = r;
        } TX_EMPTY[8:8] = 1'b0;

    } INTR_ENABLE @ 0x04;

    reg {
        name = "Interrupt Test Register";
        desc = "Interrupt Test Register";

        field {
            desc = "Write 1 to force tx_watermark to 1.";
            sw = w; hw = r; swwe;
        } TX_WATERMARK[0:0] = 1'b0;

        field {
            desc = "Write 1 to force rx_watermark to 1.";
            sw = w; hw = r; swwe;
        } RX_WATERMARK[1:1] = 1'b0;

        field {
            desc = "Write 1 to force tx_done to 1.";
            sw = w; hw = r; swwe;
        } TX_DONE[2:2] = 1'b0;

        field {
            desc = "Write 1 to force rx_overflow to 1.";
            sw = w; hw = r; swwe;
        } RX_OVERFLOW[3:3] = 1'b0;

        field {
            desc = "Write 1 to force rx_frame_err to 1.";
            sw = w; hw = r; swwe;
        } RX_FRAME_ERR[4:4] = 1'b0;

        field {
            desc = "Write 1 to force rx_break_err to 1.";
            sw = w; hw = r; swwe;
        } RX_BREAK_ERR[5:5] = 1'b0;

        field {
            desc = "Write 1 to force rx_timeout to 1.";
            sw = w; hw = r; swwe;
        } RX_TIMEOUT[6:6] = 1'b0;

        field {
            desc = "Write 1 to force rx_parity_err to 1.";
            sw = w; hw = r; swwe;
        } RX_PARITY_ERR[7:7] = 1'b0;

        field {
            desc = "Write 1 to force tx_empty to 1.";
            sw = w; hw = r; swwe;
        } TX_EMPTY[8:8] = 1'b0;

    } INTR_TEST @ 0x08;

    reg {
        name = "UART Control Register";
        desc = "UART control register";

        field {
            desc = "TX enable";
            sw = rw; hw = r;
        } TX[0:0] = 1'b0;

        field {
            desc = "RX enable";
            sw = rw; hw = r;
        } RX[1:1] = 1'b0;

        field {
            desc = "RX noise filter enable. If the noise filter is enabled, RX line goes
            through the 3-tap repetition code. It ignores single IP clock period noise.";
            sw = rw; hw = r;
        } NF[2:2] = 1'b0;

        field {
            desc = "System loopback enable. If this bit is turned on, any outgoing bits
            to TX are received through RX.";
            sw = rw; hw = r;
        } SLPBK[4:4] = 1'b0;

        field {
            desc = "Line loopback enable. If this bit is turned on, incoming bits are
            forwarded to TX for testing purpose.";
            sw = rw; hw = r;
        } LLPBK[5:5] = 1'b0;

        field {
            desc = "If true, parity is enabled in both RX and TX directions.";
            sw = rw; hw = r;
        } PARITY_EN[6:6] = 1'b0;

        field {
            desc = "If PARITY_EN is true, this determines the type, 1 for odd parity,
            0 for even.";
            sw = rw; hw = r;
        } PARITY_ODD[7:7] = 1'b0;

        field {
            desc = "Trigger level for RX break detection. Sets the number of character
            times the line must be low to detect a break.";
            sw = rw; hw = r;
        } RXBLVL[9:8] = 2'h0;

        field {
            desc = "BAUD clock rate control.";
            sw = rw; hw = r;
        } NCO[31:16] = 16'h0000;

    } CTRL @ 0x0C;

    reg {
        name = "UART Live Status Register";
        desc = "UART live status register";

        field {
            desc = "TX buffer is full";
            sw = r; hw = w;
        } TXFULL[0:0] = 1'b0;

        field {
            desc = "RX buffer is full";
            sw = r; hw = w;
        } RXFULL[1:1] = 1'b0;

        field {
            desc = "TX FIFO is empty";
            sw = r; hw = w;
        } TXEMPTY[2:2] = 1'b1;

        field {
            desc = "TX FIFO is empty and all bits have been transmitted";
            sw = r; hw = w;
        } TXIDLE[3:3] = 1'b1;

        field {
            desc = "RX is idle";
            sw = r; hw = w;
        } RXIDLE[4:4] = 1'b1;

        field {
            desc = "RX FIFO is empty";
            sw = r; hw = w;
        } RXEMPTY[5:5] = 1'b1;

    } STATUS @ 0x10;

    reg {
        name = "UART Read Data";
        desc = "UART read data";

        field {
            desc = "RX data byte read from receive FIFO.";
            sw = r; hw = w;
        } RDATA[7:0] = 8'h00;

    } RDATA @ 0x14;

    reg {
        name = "UART Write Data";
        desc = "UART write data";

        field {
            desc = "TX data byte written to transmit FIFO.";
            sw = w; hw = r;
        } WDATA[7:0] = 8'h00;

    } WDATA @ 0x18;

    reg {
        name = "UART FIFO Control Register";
        desc = "UART FIFO control register";

        field {
            desc = "RX fifo reset. Write 1 to reset RX FIFO. Read returns 0.";
            sw = w; hw = r; swwe;
        } RXRST[0:0] = 1'b0;

        field {
            desc = "TX fifo reset. Write 1 to reset TX FIFO. Read returns 0.";
            sw = w; hw = r; swwe;
        } TXRST[1:1] = 1'b0;

        field {
            desc = "Trigger level for RX interrupts. If the FIFO depth is greater than
            or equal to the setting, it raises rx_watermark interrupt.";
            sw = rw; hw = rw; swwe;
        } RXILVL[4:2] = 3'h0;

        field {
            desc = "Trigger level for TX interrupts. If the FIFO depth is less than the
            setting, it raises tx_watermark interrupt.";
            sw = rw; hw = rw; swwe;
        } TXILVL[7:5] = 3'h0;

    } FIFO_CTRL @ 0x1C;

    reg {
        name = "UART FIFO Status Register";
        desc = "UART FIFO status register";

        field {
            desc = "Current fill level of TX FIFO";
            sw = r; hw = w;
        } TXLVL[7:0] = 8'h00;

        field {
            desc = "Current fill level of RX FIFO";
            sw = r; hw = w;
        } RXLVL[23:16] = 8'h00;

    } FIFO_STATUS @ 0x20;

    reg {
        name = "TX Pin Override Control";
        desc = "TX pin override control. Gives direct SW control over TX pin state";

        field {
            desc = "Enable TX pin override control";
            sw = rw; hw = r;
        } TXEN[0:0] = 1'b0;

        field {
            desc = "Write to set the value of the TX pin";
            sw = rw; hw = r;
        } TXVAL[1:1] = 1'b0;

    } OVRD @ 0x24;

    reg {
        name = "UART Oversampled Values";
        desc = "UART oversampled values";

        field {
            desc = "Last 16 oversampled values of RX. Most recent bit is bit 0, oldest 15.";
            sw = r; hw = w;
        } RX[15:0] = 16'h0000;

    } VAL @ 0x28;

    reg {
        name = "UART RX Timeout Control";
        desc = "UART RX timeout control";

        field {
            desc = "RX timeout value in UART bit times";
            sw = rw; hw = r;
        } VAL[23:0] = 24'h000000;

        field {
            desc = "Enable RX timeout feature";
            sw = rw; hw = r;
        } EN[31:31] = 1'b0;

    } TIMEOUT_CTRL @ 0x2C;
};
