// SPDX-License-Identifier: Apache-2.0
//
// Licensed under the Apache License, Version 2.0 (the "License");
// you may not use this file except in compliance with the License.
// You may obtain a copy of the License at
//
// http://www.apache.org/licenses/LICENSE-2.0
//
// Unless required by applicable law or agreed to in writing, software
// distributed under the License is distributed on an "AS IS" BASIS,
// WITHOUT WARRANTIES OR CONDITIONS OF ANY KIND, either express or implied.
// See the License for the specific language governing permissions and
// limitations under the License.
//

////////////////////////////////////////////////////////////////
// Fuse Controller Registers

//parameter int OtpByteAddrWidth = 12;



addrmap otp_ctrl {
    reg {
        field {
            sw = rw;
            onwrite = woclr;
            desc = "A direct access command or digest calculation operation has completed.";
        } OTP_OPERATION_DONE[0:0];
        field {
            sw = rw;
            onwrite = woclr;
            desc = "An error has occurred in the OTP contrller. Check the !!ERR_CODE register to get more information.";
        } OTP_error[1:1];
    } INTERRUPT_STATE @ 0x0;

    reg {
        field {
            sw = rw;
            onwrite = woclr;
            desc = "Enable interrupt when otp_operation_done is set.";
        } OTP_OPERATION_DONE[0:0];
        field {
            sw = rw;
            onwrite = woclr;
            desc = "Enable interrupt when otp_error is set.";
        } OTP_error[1:1];
    } INTERRUPT_ENABLE @ 0x4;

    reg {
        field {
            sw = w;
            desc = "Write 1 to force otp_operation_done to 1.";
        } OTP_OPERATION_DONE[0:0];
        field {
            sw = w;
            desc = "Write 1 to force otp_error to 1.";
        } OTP_error[1:1];
    } INTERRUPT_TEST @ 0x8;

    reg {
        field {
            sw = w;
            desc = "Write 1 to trigger one alert event of this kind.";
        } FATAL_MACr_error[0:0];
        field {
            sw = w;
            desc = "Write 1 to trigger one alert event of this kind.";
        } FATAL_CHECK_error[1:1];
        field {
            sw = w;
            desc = "Write 1 to trigger one alert event of this kind.";
        } FATAL_BUS_INTEG_error[2:2];
        field {
            sw = w;
            desc = "Write 1 to trigger one alert event of this kind.";
        } FATAL_PRIM_OTP_ALERT[3:3];
        field {
            sw = w;
            desc = "Write 1 to trigger one alert event of this kind.";
        } RECOV_PRIM_OTP_ALERT[4:4];
    } ALERT_TEST @ 0xC;

    reg {
        field {
            sw = r;
            desc = "Set to 1 if an error occurred in this partition. If set to 1, SW should check the !!ERR_CODE register at the corresponding index.";
        } SW_TEST_UNLOCK_PARTITION_ERROR[0:0];
        field {
            sw = r;
            desc = "Set to 1 if an error occurred in this partition. If set to 1, SW should check the !!ERR_CODE register at the corresponding index.";
        } SECRET_MANUF_PARTITION_ERROR[1:1];
        field {
            sw = r;
            desc = "Set to 1 if an error occurred in this partition. If set to 1, SW should check the !!ERR_CODE register at the corresponding index.";
        } SECRET_PROD_PARTITION_0_ERROR[2:2];
        field {
            sw = r;
            desc = "Set to 1 if an error occurred in this partition. If set to 1, SW should check the !!ERR_CODE register at the corresponding index.";
        } SECRET_PROD_PARTITION_1_ERROR[3:3];
        field {
            sw = r;
            desc = "Set to 1 if an error occurred in this partition. If set to 1, SW should check the !!ERR_CODE register at the corresponding index.";
        } SECRET_PROD_PARTITION_2_ERROR[4:4];
        field {
            sw = r;
            desc = "Set to 1 if an error occurred in this partition. If set to 1, SW should check the !!ERR_CODE register at the corresponding index.";
        } SECRET_PROD_PARTITION_3_ERROR[5:5];
        field {
            sw = r;
            desc = "Set to 1 if an error occurred in this partition. If set to 1, SW should check the !!ERR_CODE register at the corresponding index.";
        } SW_MANUF_PARTITION_ERROR[6:6];
        field {
            sw = r;
            desc = "Set to 1 if an error occurred in this partition. If set to 1, SW should check the !!ERR_CODE register at the corresponding index.";
        } SECRET_LC_TRANSITION_PARTITION_ERROR[7:7];
        field {
            sw = r;
            desc = "Set to 1 if an error occurred in this partition. If set to 1, SW should check the !!ERR_CODE register at the corresponding index.";
        } SVN_PARTITION_ERROR[8:8];
        field {
            sw = r;
            desc = "Set to 1 if an error occurred in this partition. If set to 1, SW should check the !!ERR_CODE register at the corresponding index.";
        } VENDOR_TEST_PARTITION_ERROR[9:9];
        field {
            sw = r;
            desc = "Set to 1 if an error occurred in this partition. If set to 1, SW should check the !!ERR_CODE register at the corresponding index.";
        } VENDOR_HASHES_MANUF_PARTITION_ERROR[10:10];
        field {
            sw = r;
            desc = "Set to 1 if an error occurred in this partition. If set to 1, SW should check the !!ERR_CODE register at the corresponding index.";
        } VENDOR_HASHES_PROD_PARTITION_ERROR[11:11];
        field {
            sw = r;
            desc = "Set to 1 if an error occurred in this partition. If set to 1, SW should check the !!ERR_CODE register at the corresponding index.";
        } VENDOR_REVOCATIONS_PROD_PARTITION_ERROR[12:12];
        field {
            sw = r;
            desc = "Set to 1 if an error occurred in this partition. If set to 1, SW should check the !!ERR_CODE register at the corresponding index.";
        } VENDOR_SECRET_PROD_PARTITION_ERROR[13:13];
        field {
            sw = r;
            desc = "Set to 1 if an error occurred in this partition. If set to 1, SW should check the !!ERR_CODE register at the corresponding index.";
        } VENDOR_NON_SECRET_PROD_PARTITION_ERROR[14:14];
        field {
            sw = r;
            desc = "Set to 1 if an error occurred in this partition. If set to 1, SW should check the !!ERR_CODE register at the corresponding index.";
        } LIFE_CYCLE_ERROR[15:15];
        field {
            sw = r;
            desc = "Set to 1 if an error occurred in this partition. If set to 1, SW should check the !!ERR_CODE register at the corresponding index.";
        } DAI_ERROR[16:16];
        field {
            sw = r;
            desc = "Set to 1 if an error occurred in this partition. If set to 1, SW should check the !!ERR_CODE register at the corresponding index.";
        } LCI_ERROR[17:17];
        field {
            sw = r;
            desc = "Set to 1 if an error occurred in this partition. If set to 1, SW should check the !!ERR_CODE register at the corresponding index.";
        } TIMEOUT_ERROR[18:18];
        field {
            sw = r;
            desc = "Set to 1 if the LFSR timer FSM has reached an invalid state. This raises an fatal_check_error alert and is an unrecoverable error condition.";
        } LFSR_FSM_ERROR[19:19];
        field {
            sw = r;
            desc = "Set to 1 if the scrambling datapath FSM has reached an invalid state. This raises an fatal_check_error alert and is an unrecoverable error condition.";
        } SCRAMBLING_FSM_ERROR[20:20];
        field {
            sw = r;
            desc = "This bit is set to 1 if a fatal bus integrity fault is detected. This error triggers a fatal_bus_integ_error alert.";
        } BUS_INTEG_ERROR[21:21];
        field {
            sw = r;
            desc = "Set to 1 if the DAI is idle and ready to accept commands.";
        } DAI_IDLE[22:22];
        field {
            sw = r;
            desc = "Set to 1 if an integrity or consistency check triggered by the LFSR timer or via !!CHECK_TRIGGER is pending.";
        } CHECK_PENDING[23:23];
    } STATUS @ 0x10;

    regfile err_code_t {

        /* -----------------------------------
        * Default prperties for Register File
        * --------------------------------- */

        name = "error Code Register Block";
        desc = "Set of registers to implement error_code functionality
                for Fuse Contrller.";
                
        default regwidth = 32; // reg property
        default accesswidth = 32; // reg property
        default sw = r; // field property
        default hw = w; // field property

        /* ------------------------------------
        * Register definitions
        * -----------------------------------*/
        reg err_code_reg_t {
            desc = "This register holds information about error conditions that occurred in the agents
                    interacting with the OTP macr via the internal bus. The error codes should be checked
                    if the partitions, DAI or LCI flag an error in the !!STATUS register, or when an
                    !!INTR_STATE.otp_error has been triggered. Note that all errors trigger an otp_error
                    interrupt, and in addition some errors may trigger either an fatal_macr_error or an
                    fatal_check_error alert.";

            default sw = r; // field property
            default hw = w; // field property

            // 0x0 (NO_ERROR): No error condition has occurred.
            // 0x1 (MACRO_ERROR): Returned if the OTP macro command was invalid or did not complete successfully due to a macro malfunction.
            //   This error should never occur during normal operation and is not recoverable. This error triggers an fatal_macro_error alert.
            // 0x2 (MACRO_ECC_CORR_ERROR): A correctable ECC error has occured during an OTP read operation. The corresponding controller
            //   automatically recovers from this error when issuing a new command.
            // 0x3 (MACRO_ECC_UNCORR_ERROR): An uncorrectable ECC error has occurred during an OTP read operation. This error should never occur
            //   during normal operation and is not recoverable. If this error is present this may be a sign that the device is malfunctioning.
            //   This error triggers an fatal_macro_error alert.
            // 0x4 (MACRO_WRITE_BLANK_ERROR): This error is returned if a programming operation attempted to clear a bit that has previously been programmed to 1.
            //   The corresponding controller automatically recovers from this error when issuing a new command. Note however that the affected OTP word may be left
            //   in an inconsistent state if this error occurs. This can cause several issues when the word is accessed again (either as part of a regular read operation,
            //   as part of the readout at boot, or as part of a background check). It is important that SW ensures that each word is only written once, since this can render the device useless.
            // 0x5 (ACCESS_ERROR): This error indicates that a locked memory region has been accessed. The corresponding controller automatically recovers from this error when issuing a new command.
            // 0x6 (CHECK_FAIL_ERROR): An ECC, integrity or consistency mismatch has been detected in the buffer registers. This error should never occur during normal
            //   operation and is not recoverable. This error triggers an fatal_check_error alert.
            // 0x7 (FSM_STATE_ERROR): The FSM of the corresponding controller has reached an invalid state, or the FSM has been moved into a terminal error state due to an
            //   escalation action via lc_escalate_en_i. This error should never occur during normal operation and is not recoverable. If this error is present, this is a sign that
            //   the device has fallen victim to an invasive attack. This error triggers an fatal_check_error alert.
            field {
                desc = "This register holds information about error conditions that occurred in the agents interacting with the OTP macro via the internal bus.";
            } ERR_CODE [2:0];
        };

        /* ----------- Registers ------------*/
        err_code_reg_t ERR_CODE_0  @0x0;     //
        err_code_reg_t ERR_CODE_1  @0x4;     //
        err_code_reg_t ERR_CODE_2  @0x8;     //
        err_code_reg_t ERR_CODE_3  @0xC;     //
        err_code_reg_t ERR_CODE_4  @0x10;     //
        err_code_reg_t ERR_CODE_5  @0x14;     //
        err_code_reg_t ERR_CODE_6  @0x18;     //
        err_code_reg_t ERR_CODE_7  @0x1C;     //
        err_code_reg_t ERR_CODE_8  @0x20;     //
        err_code_reg_t ERR_CODE_9  @0x24;     //
        err_code_reg_t ERR_CODE_10  @0x28;     //
        err_code_reg_t ERR_CODE_11  @0x2C;     //
        err_code_reg_t ERR_CODE_12  @0x30;     //
        err_code_reg_t ERR_CODE_13  @0x34;     //
        err_code_reg_t ERR_CODE_14  @0x38;     //
        err_code_reg_t ERR_CODE_15  @0x3C;     //
        err_code_reg_t ERR_CODE_16  @0x40;     //
        err_code_reg_t ERR_CODE_17  @0x44;     //
        /* ----------------------------------*/
    };

    err_code_t err_code_rf @ 0x14;

    reg {
        desc = "Register write enable for all direct access interface registers.";
        default sw = rw;
        default onwrite = wzc;
        default hw = rw;
        //default hwext = true;
        field {
            desc = "This bit contrls whether the DAI registers can be written.Write 0 to it in order to clear the bit.Note that the hardware also modulates this bit and sets it to 0 temporarilyduring an OTP operation such that the corresponding address and data registerscannot be modified while an operation is pending. The !!DAI_IDLE status bitwill also be set to 0 in such a case.";
            reset = 0x1;
        } REGWEN [0:0];
    } DIRECT_ACCESS_REGWEN @ 0x5C;

    reg {
        desc = "Command register for direct accesses.";
        default sw = w;
        default onwrite = wzc;
        default hw = r;
        //hwext = true;
        default reset = 0x0; 
        //default swwe = DIRECT_ACCESS_REGWEN;
        field { 
            desc = "Initiates a readout sequence that reads the location specifiedby !!DIRECT_ACCESS_ADDRESS. The command places the data read into!!DIRECT_ACCESS_RDATA_0 and !!DIRECT_ACCESS_RDATA_1 (for 64bit partitions).";
        } RD [0:0];
        field { 
            desc = "Initiates a prgramming sequence that writes the data in !!DIRECT_ACCESS_WDATA_0and !!DIRECT_ACCESS_WDATA_1 (for 64bit partitions) to the location specified by!!DIRECT_ACCESS_ADDRESS.";
        } WR [1:1];
        field { 
            desc = "Initiates the digest calculation and locking sequence for the partition specified by!!DIRECT_ACCESS_ADDRESS.";
        } DIGEST [2:2];
    } DIRECT_ACCESS_CMD @ 0x60;

    DIRECT_ACCESS_CMD.RD -> swwe = DIRECT_ACCESS_REGWEN.REGWEN;
    DIRECT_ACCESS_CMD.WR -> swwe = DIRECT_ACCESS_REGWEN.REGWEN;
    DIRECT_ACCESS_CMD.DIGEST -> swwe = DIRECT_ACCESS_REGWEN.REGWEN;

    reg {
        desc = "Address register for direct accesses.";
        default sw = rw;
        default hw = r;
        default reset = 0x0;
        //default swwe = DIRECT_ACCESS_REGWEN;
        field {
            desc = "This is the address for the OTP word to be read or written thrughthe direct access interface. Note that the address is aligned to the access sizeinternally, hence bits 1:0 are ignored for 32bit accesses, and bits 2:0 are ignoredfor 64bit accesses.For the digest calculation command, set this register to the partition base offset.";
        } ADDRESS [11:0];
    } DIRECT_ACCESS_ADDRESS @ 0x64;

    DIRECT_ACCESS_ADDRESS.ADDRESS -> swwe = DIRECT_ACCESS_REGWEN.REGWEN;

    regfile dir_acc_wdata_t {
        /* -----------------------------------
        * Default prperties for Register File
        * --------------------------------- */

        name = "Direct Access Wdata Register Block";
        desc = "Set of registers to implement wdata functionality
                for Fuse Contrller."; 
        default reset = 0x0; 
        //default swwe = DIRECT_ACCESS_REGWEN;
        default regwidth = 32; // reg property
        default accesswidth = 32; // reg property
        default sw = r; // field property
        default hw = w; // field property
        //defalt hwext = true;

        /* ------------------------------------
        * Register definitions
        * -----------------------------------*/
        reg dai_wdata_t {
            desc = "Write data for direct accesses. 
                    Hardware automatically determines the access granule (32bit or 64bit) based on which 
                    partition is being written to.";

            default sw = rw; // field prperty
            default hw = w; // field prperty

            field { desc = "wdata.";} WDATA [31:0];
        };

        /* ------------- Registers --------------*/
        dai_wdata_t DIRECT_ACCESS_WDATA_0 @ 0x0; //
        dai_wdata_t DIRECT_ACCESS_WDATA_1 @ 0x4; //  
        /* --------------------------------------*/
    };

    dir_acc_wdata_t dai_wdata_rf @ 0x68;

    dai_wdata_rf.DIRECT_ACCESS_WDATA_0.WDATA -> swwe = DIRECT_ACCESS_REGWEN.REGWEN;
    dai_wdata_rf.DIRECT_ACCESS_WDATA_1.WDATA -> swwe = DIRECT_ACCESS_REGWEN.REGWEN;

    regfile dir_acc_rdata_t {
        /* -----------------------------------
        * Default prperties for Register File
        * --------------------------------- */

        name = "Direct Access Wdata Register Block";
        desc = "Set of registers to implement wdata functionality
                for Fuse Contrller."; 
        default reset = 0x0; 
                
        default regwidth = 32; // reg prperty
        default accesswidth = 32; // reg prperty
        default sw = r; // field prperty
        default hw = w; // field prperty
        //default hwext = true;

        /* ------------------------------------
        * Register definitions
        * -----------------------------------*/
        reg dai_rdata_t {
            desc = "Read data for direct accesses. 
            Hardware automatically determines the access granule (32bit or 64bit) based on which 
            partition is read from.";

            default sw = r; // field prperty
            default hw = w; // field prperty

            field { desc = "rdata.";} RDATA [31:0];
        };

        /* ------------- Registers --------------*/
        dai_rdata_t DIRECT_ACCESS_RDATA_0 @ 0x0; //
        dai_rdata_t DIRECT_ACCESS_RDATA_1 @ 0x4; //  
        /* --------------------------------------*/
    };

    dir_acc_rdata_t dai_rdata_rf @ 0x70;

    reg {
        desc = "Register write enable for !!CHECK_TRIGGER.";
        default sw = rw;
        default onwrite = wzc;
        default hw = na;
        field {
            desc = "When cleared to 0, the !!CHECK_TRIGGER register cannot be written anymore. 
                    Write 0 to clear this bit.";
            reset = 0x1;
        }  REGWEN [0:0];
    } CHECK_TRIGGER_REGWEN @ 0x78;

    reg {
        desc = "Command register for direct accesses.";
        default sw = w;
        default onwrite = woclr;
        default hw = r; // Needs to read 0
        //hwext = true;
        default reset = 0x0;
        //default swwe = CHECK_TRIGGER_REGWEN;
        field {
            desc = "Writing 1 to this bit triggers an integrity check. SW should monitor !!STATUS.CHECK_PENDING 
                    and wait until the check has been completed. If there are any errors, those will be flagged 
                    in the !!STATUS and !!ERR_CODE registers, and via the interrupts and alerts.";
        } INTEGRITY[0:0];
        field {
            desc = "Writing 1 to this bit triggers a consistency check. SW should monitor !!STATUS.CHECK_PENDINGand wait until the check has been completed. If there are any errors, those will be flaggedin the !!STATUS and !!ERR_CODE registers, and via interrupts and alerts.";
        } CONSISTENCY[1:1];
    } CHECK_TRIGGER @ 0x7C;

    CHECK_TRIGGER.INTEGRITY -> swwe = CHECK_TRIGGER_REGWEN.REGWEN;
    CHECK_TRIGGER.CONSISTENCY -> swwe = CHECK_TRIGGER_REGWEN.REGWEN;

    reg {
        desc = "Register write enable for !!INTEGRITY_CHECK_PERIOD and !!CONSISTENCY_CHECK_PERIOD.";
        default sw = w;
        default onwrite = wzc;
        default hw = na;
        field {
            desc = "When cleared to 0, !!INTEGRITY_CHECK_PERIOD and !!CONSISTENCY_CHECK_PERIOD registers cannot be written anymore.Write 0 to clear this bit.";
            reset = 0x1;
        } REGWEN [0:0];
    } CHECK_REGWEN @ 0x80;

    reg {
        desc = "Timeout value for the integrity and consistency checks.";
        default sw = rw;
        default hw = r;
        //default swwe = CHECK_REGWEN;
        field {
            desc = "Timeout value in cycles for the for the integrity and consistency checks. If an integrity or consistency
                    check does not complete within the timeout window, an error will be flagged in the !!STATUS register, 
                    an otp_error interrupt will be raised, and an fatal_check_error alert will be sent out. The timeout should 
                    be set to a large value to stay on the safe side. The maximum check time can be upper bounded by the 
                    number of cycles it takes to readout, scramble and digest the entire OTP array. Since this amounts to 
                    rughly 25k cycles, it is recommended to set this value to at least 100'000 cycles in order to stay on the 
                    safe side. A value of zer disables the timeout mechanism (default).";
            reset = 0x0;
        } TIMEOUT [31:0];
    } CHECK_TIMEOUT @ 0x84;

    CHECK_TIMEOUT.TIMEOUT -> swwe = CHECK_REGWEN.REGWEN;

    reg {
        desc = "This value specifies the maximum period that can be generated pseudo-randomly.Only applies to the HW_CFG* and SECRET* partitions once they are locked.";
        default sw = rw;
        default hw = r;
        //default swwe = CHECK_REGWEN;
        field {
            desc = "The pseudo-random period is generated using a 40bit LFSR internally, and this register defines 
            the bit mask to be applied to the LFSR output in order to limit its range. The value of this 
            register is left shifted by 8bits and the lower bits are set to 8'hFF in order to form the 40bit mask. 
            A recommended value is 0x3_FFFF, corresponding to a maximum period of ~2.8s at 24MHz. 
            A value of zer disables the timer (default). Note that a one-off check can always be triggered via 
            !!CHECK_TRIGGER.INTEGRITY.";
            reset = 0x0;
        } PERIOD [31:0];
    } INTEGRITY_CHECK_PERIOD @ 0x88;

    INTEGRITY_CHECK_PERIOD.PERIOD -> swwe = CHECK_REGWEN.REGWEN;

    reg {
        desc = "This value specifies the maximum period that can be generated pseudo-randomly.This applies to the LIFE_CYCLE partition and the HW_CFG* and SECRET* partitions once they are locked.";
        default sw = rw;
        default hw = r;
        //default swwe = CHECK_REGWEN;
        field {
            desc = "The pseudo-random period is generated using a 40bit LFSR internally, and this register definesthe bit mask to be applied to the LFSR output in order to limit its range. The value of thisregister is left shifted by 8bits and the lower bits are set to 8'hFF in order to form the 40bit mask.A recommended value is 0x3FF_FFFF, corresponding to a maximum period of ~716s at 24MHz.A value of zer disables the timer (default). Note that a one-off check can always be triggered via!!CHECK_TRIGGER.CONSISTENCY.";
            reset = 0x0;
        } PERIOD [31:0];
    } CONSISTENCY_CHECK_PERIOD @ 0x8C;

    CONSISTENCY_CHECK_PERIOD.PERIOD -> swwe = CHECK_REGWEN.REGWEN;

    reg {
    desc = "Runtime read lock for the SW_MANUF_PARTITION partition.";
        default sw = rw;
        default onwrite = wzc;
        default hw = r;
        //default swwe = DIRECT_ACCESS_REGWEN;
        field {
            desc = "When cleared to 0, read access to the SW_MANUF_PARTITION partition is locked.Write 0 to clear this bit.";
            reset = 0x1;
        } READ_LOCK [0:0];
    } SW_MANUF_PARTITION_READ_LOCK @0x90;

    SW_MANUF_PARTITION_READ_LOCK.READ_LOCK -> swwe = DIRECT_ACCESS_REGWEN.REGWEN;

    reg {
    desc = "Runtime read lock for the SVN_PARTITION partition.";
        default sw = rw;
        default onwrite = wzc;
        default hw = r;
        //default swwe = DIRECT_ACCESS_REGWEN;
        field {
            desc = "When cleared to 0, read access to the SVN_PARTITION partition is locked.Write 0 to clear this bit.";
            reset = 0x1;
        } READ_LOCK [0:0];
    } SVN_PARTITION_READ_LOCK @0x94;

    SVN_PARTITION_READ_LOCK.READ_LOCK -> swwe = DIRECT_ACCESS_REGWEN.REGWEN;

    reg {
    desc = "Runtime read lock for the VENDOR_TEST_PARTITION partition.";
        default sw = rw;
        default onwrite = wzc;
        default hw = r;
        //default swwe = DIRECT_ACCESS_REGWEN;
        field {
            desc = "When cleared to 0, read access to the VENDOR_TEST_PARTITION partition is locked.Write 0 to clear this bit.";
            reset = 0x1;
        } READ_LOCK [0:0];
    } VENDOR_TEST_PARTITION_READ_LOCK @0x98;

    VENDOR_TEST_PARTITION_READ_LOCK.READ_LOCK -> swwe = DIRECT_ACCESS_REGWEN.REGWEN;

    reg {
    desc = "Runtime read lock for the VENDOR_HASHES_MANUF_PARTITION partition.";
        default sw = rw;
        default onwrite = wzc;
        default hw = r;
        //default swwe = DIRECT_ACCESS_REGWEN;
        field {
            desc = "When cleared to 0, read access to the VENDOR_HASHES_MANUF_PARTITION partition is locked.Write 0 to clear this bit.";
            reset = 0x1;
        } READ_LOCK [0:0];
    } VENDOR_HASHES_MANUF_PARTITION_READ_LOCK @0x9C;

    VENDOR_HASHES_MANUF_PARTITION_READ_LOCK.READ_LOCK -> swwe = DIRECT_ACCESS_REGWEN.REGWEN;

    reg {
    desc = "Runtime read lock for the VENDOR_HASHES_PROD_PARTITION partition.";
        default sw = rw;
        default onwrite = wzc;
        default hw = r;
        //default swwe = DIRECT_ACCESS_REGWEN;
        field {
            desc = "When cleared to 0, read access to the VENDOR_HASHES_PROD_PARTITION partition is locked.Write 0 to clear this bit.";
            reset = 0x1;
        } READ_LOCK [0:0];
    } VENDOR_HASHES_PROD_PARTITION_READ_LOCK @0xA0;

    VENDOR_HASHES_PROD_PARTITION_READ_LOCK.READ_LOCK -> swwe = DIRECT_ACCESS_REGWEN.REGWEN;

    reg {
    desc = "Runtime read lock for the VENDOR_REVOCATIONS_PROD_PARTITION partition.";
        default sw = rw;
        default onwrite = wzc;
        default hw = r;
        //default swwe = DIRECT_ACCESS_REGWEN;
        field {
            desc = "When cleared to 0, read access to the VENDOR_REVOCATIONS_PROD_PARTITION partition is locked.Write 0 to clear this bit.";
            reset = 0x1;
        } READ_LOCK [0:0];
    } VENDOR_REVOCATIONS_PROD_PARTITION_READ_LOCK @0xA4;

    VENDOR_REVOCATIONS_PROD_PARTITION_READ_LOCK.READ_LOCK -> swwe = DIRECT_ACCESS_REGWEN.REGWEN;

    reg {
    desc = "Runtime read lock for the VENDOR_NON_SECRET_PROD_PARTITION partition.";
        default sw = rw;
        default onwrite = wzc;
        default hw = r;
        //default swwe = DIRECT_ACCESS_REGWEN;
        field {
            desc = "When cleared to 0, read access to the VENDOR_NON_SECRET_PROD_PARTITION partition is locked.Write 0 to clear this bit.";
            reset = 0x1;
        } READ_LOCK [0:0];
    } VENDOR_NON_SECRET_PROD_PARTITION_READ_LOCK @0xA8;

    VENDOR_NON_SECRET_PROD_PARTITION_READ_LOCK.READ_LOCK -> swwe = DIRECT_ACCESS_REGWEN.REGWEN;


    reg {
        desc = "Volatile write lock for vendor public key hashes.";
        default sw = rw;
        default hw = r;
        field {
            desc = "One-hot encoded";
            reset = 0x0;
        } PERIOD [31:0];
    } VENDOR_PK_HASH_VOLATILE_LOCK @ 0xAC;

    regfile digest_t {
        /* -----------------------------------
        * Default prperties for Register File
        * --------------------------------- */
        name = "DIGEST";
        desc = "Digest register block";
        default reset = 0x0;

        default sw = r;
        default hw = r;
        //default hwext = true;
        
        /* ------------------------------------
        * Register definitions
        * -----------------------------------*/
        reg digest_reg_t {
            name = "DIGEST";
            desc = "Integrity digest for partition. 
            The integrity digest is 0 by default. Software must write this 
            digest value via the direct access interface in order to lock the partition. 
            After a reset, write access to the VENDOR_TEST partition is locked and  the digest becomes visible in this CSR.";

            default sw = r; // field prperty
            default hw = w; // field prperty

            field { desc = "Digest.";} DIGEST [31:0];
        };

        /* ------------- Registers --------------*/
        digest_reg_t DIGEST_0 @ 0x0; //
        digest_reg_t DIGEST_1 @ 0x4; //  
        /* --------------------------------------*/
    };

    digest_t SW_TEST_UNLOCK_PARTITION_DIGEST @ 0xB0;
    digest_t SECRET_MANUF_PARTITION_DIGEST @ 0xB8;
    digest_t SECRET_PROD_PARTITION_0_DIGEST @ 0xC0;
    digest_t SECRET_PROD_PARTITION_1_DIGEST @ 0xC8;
    digest_t SECRET_PROD_PARTITION_2_DIGEST @ 0xD0;
    digest_t SECRET_PROD_PARTITION_3_DIGEST @ 0xD8;
    digest_t SW_MANUF_PARTITION_DIGEST @ 0xE0;
    digest_t SECRET_LC_TRANSITION_PARTITION_DIGEST @ 0xE8;
    digest_t VENDOR_TEST_PARTITION_DIGEST @ 0xF0;
    digest_t VENDOR_HASHES_MANUF_PARTITION_DIGEST @ 0xF8;
    digest_t VENDOR_HASHES_PROD_PARTITION_DIGEST @ 0x100;
    digest_t VENDOR_REVOCATIONS_PROD_PARTITION_DIGEST @ 0x108;
    digest_t VENDOR_SECRET_PROD_PARTITION_DIGEST @ 0x110;
    digest_t VENDOR_NON_SECRET_PROD_PARTITION_DIGEST @ 0x118;

    reg {
        field {
            desc = "";
            sw = rw;
            hw = r;
        } field0[0:0] = 0x0;
        field {
            desc = "";
            sw = rw;
            hw = r;
        } field1[1:1] = 0x0;
        field {
            desc = "";
            sw = rw;
            hw = r;
        } field2[2:2] = 0x0;
        field {
            desc = "";
            sw = rw;
            hw = r;
        } field3[13:4] = 0x0;
        field {
            desc = "";
            sw = rw;
            hw = r;
        } field4[26:16] = 0x0;
    } CSR0 @ 0x120;

    reg {
        field {
            desc = "";
            sw = rw;
            hw = r;
        } field0[6:0] = 0x0;
        field {
            desc = "";
            sw = rw;
            hw = r;
        } field1[7:7] = 0x0;
        field {
            desc = "";
            sw = rw;
            hw = r;
        } field2[14:8] = 0x0;
        field {
            desc = "";
            sw = rw;
            hw = r;
        } field3[15:15] = 0x0;
        field {
            desc = "";
            sw = rw;
            hw = r;
        } field4[31:16] = 0x0;
    } CSR1 @ 0x124;

    reg {
        field {
            desc = "";
            sw = rw;
            hw = r;
        } field0[0:0] = 0x0;
    } CSR2 @ 0x128;

    reg {
        field {
            desc = "";
            sw = rw;
            hw = rw;
        } field0[2:0] = 0x0;
        field {
            desc = "";
            sw = rw;
            onwrite = woclr;
            hw = rw;
        } field1[13:4] = 0x0;
        field {
            desc = "";
            sw = rw;
            onwrite = woclr;
            hw = rw;
        } field2[16:16] = 0x0;
        field {
            desc = "";
            sw = r;
            hw = rw;
        } field3[17:17] = 0x0;
        field {
            desc = "";
            sw = r;
            hw = rw;
        } field4[18:18] = 0x0;
        field {
            desc = "";
            sw = r;
            hw = rw;
        } field5[19:19] = 0x0;
        field {
            desc = "";
            sw = r;
            hw = rw;
        } field6[20:20] = 0x0;
        field {
            desc = "";
            sw = r;
            hw = rw;
        } field7[21:21] = 0x0;
        field {
            desc = "";
            sw = r;
            hw = rw;
        } field8[22:22] = 0x0;
    } CSR3 @ 0x12C;

    reg {
        field {
            desc = "";
            sw = rw;
            hw = r;
        } field0[9:0] = 0x0;
        field {
            desc = "";
            sw = rw;
            hw = r;
        } field1[12:12] = 0x0;
        field {
            desc = "";
            sw = rw;
            hw = r;
        } field2[13:13] = 0x0;
        field {
            desc = "";
            sw = rw;
            hw = r;
        } field3[14:14] = 0x0;
    } CSR4 @ 0x130;

    reg {
        field {
            desc = "";
            sw = rw;
            hw = rw;
        } field0[5:0] = 0x0;
        field {
            desc = "";
            sw = rw;
            hw = rw;
        } field1[7:6] = 0x0;
        field {
            desc = "";
            sw = r;
            hw = rw;
        } field2[8:8] = 0x0;
        field {
            desc = "";
            sw = r;
            hw = rw;
        } field3[11:9] = 0x0;
        field {
            desc = "";
            sw = r;
            hw = rw;
        } field4[12:12] = 0x0;
        field {
            desc = "";
            sw = r;
            hw = rw;
        } field5[13:13] = 0x0;
        field {
            desc = "";
            sw = rw;
            hw = rw;
        } field6[31:16] = 0x0;
    } CSR5 @ 0x134;

    reg {
        field {
            desc = "";
            sw = rw;
            hw = r;
        } field0[9:0] = 0x0;
        field {
            desc = "";
            sw = rw;
            hw = rw;
        } field1[11:11] = 0x0;
        field {
            desc = "";
            sw = rw;
            hw = rw;
        } field2[12:12] = 0x0;
        field {
            desc = "";
            sw = rw;
            hw = rw;
        } field3[31:16] = 0x0;
    } CSR6 @ 0x138;

    reg {
        field {
            desc = "";
            sw = r;
            hw = rw;
        } field0[5:0] = 0x0;
        field {
            desc = "";
            sw = r;
            hw = rw;
        } field1[10:8] = 0x0;
        field {
            desc = "";
            sw = r;
            hw = rw;
        } field2[14:14] = 0x0;
        field {
            desc = "";
            sw = r;
            hw = rw;
        } field3[15:15] = 0x0;
    } CSR7 @ 0x13C;
};