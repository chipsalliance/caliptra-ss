// Copyright lowRISC contributors (OpenTitan project).
// Licensed under the Apache License, Version 2.0, see LICENSE for details.
// SPDX-License-Identifier: Apache-2.0
//
// SPI Host register map.

addrmap spi_host {
    reg {
        name = "Interrupt State Register";
        desc = "Interrupt State Register";

        field {
            desc = "Error-related interrupts, see ERROR_ENABLE register for more
            information.";
            sw = rw; hw = rw; onwrite = woclr;
        } ERROR[0:0] = 1'b0;

        field {
            desc = "Event-related interrupts, see EVENT_ENABLE register for more
            information.";
            sw = r; hw = rw;
        } SPI_EVENT[1:1] = 1'b0;

    } INTR_STATE @ 0x00;

    reg {
        name = "Interrupt Enable Register";
        desc = "Interrupt Enable Register";

        field {
            desc = "Enable interrupt when error is set.";
            sw = rw; hw = r;
        } ERROR[0:0] = 1'b0;

        field {
            desc = "Enable interrupt when spi_event is set.";
            sw = rw; hw = r;
        } SPI_EVENT[1:1] = 1'b0;

    } INTR_ENABLE @ 0x04;

    reg {
        name = "Interrupt Test Register";
        desc = "Interrupt Test Register";

        field {
            desc = "Write 1 to force error to 1.";
            sw = w; hw = r; swwe;
        } ERROR[0:0] = 1'b0;

        field {
            desc = "Write 1 to force spi_event to 1.";
            sw = w; hw = r; swwe;
        } SPI_EVENT[1:1] = 1'b0;

    } INTR_TEST @ 0x08;

    reg {
        name = "Control Register";
        desc = "Control register";

        field {
            desc = "If EVENT_ENABLE.RXWM is set, the IP will send an interrupt when
            the depth of the RX FIFO reaches RX_WATERMARK words (32b each).";
            sw = rw; hw = r;
        } RX_WATERMARK[7:0] = 8'h7F;

        field {
            desc = "If EVENT_ENABLE.TXWM is set, the IP will send an interrupt when
            the depth of the TX FIFO drops below TX_WATERMARK words (32b each).";
            sw = rw; hw = r;
        } TX_WATERMARK[15:8] = 8'h00;

        field {
            desc = "Enable the SPI host output buffers for the sck, csb, and sd
            lines. This allows the SPI_HOST IP to connect to the same bus as other
            SPI controllers without interference.";
            sw = rw; hw = r;
        } OUTPUT_EN[29:29] = 1'b0;

        field {
            desc = "Clears the entire IP to the reset state when set to 1, including
            the FIFOs, the CDC's, the core state machine and the shift register.
            In the current implementation the CDC FIFOs are drained not reset.
            Software must confirm that both FIFOs are empty before releasing the IP
            from reset.";
            sw = rw; hw = r;
        } SW_RST[30:30] = 1'b0;

        field {
            desc = "Enables the SPI host. On reset this field is 0, meaning that no
            transactions can proceed.";
            sw = rw; hw = r;
        } SPIEN[31:31] = 1'b0;

    } CONTROL @ 0x0C;

    reg {
        name = "Status Register";
        desc = "Status register";

        field {
            desc = "Transmit queue depth. Indicates how many unsent 32-bit words are
            currently in the TX FIFO. When active this result may be an overestimate
            due to synchronization delays.";
            sw = r; hw = w;
        } TXQD[7:0] = 8'h00;

        field {
            desc = "Receive queue depth. Indicates how many unread 32-bit words are
            currently in the RX FIFO. When active this result may be an underestimate
            due to synchronization delays.";
            sw = r; hw = w;
        } RXQD[15:8] = 8'h00;

        field {
            desc = "Command queue depth. Indicates how many unread 32-bit words are
            currently in the command segment queue.";
            sw = r; hw = w;
        } CMDQD[19:16] = 4'h0;

        field {
            desc = "If high, the number of 32-bit words in the RX FIFO now exceeds
            the CONTROL.RX_WATERMARK entries (32b each).";
            sw = r; hw = w;
        } RXWM[20:20] = 1'b0;

        field {
            desc = "The value of the ByteOrder parameter, provided so that firmware
            can confirm proper IP configuration.";
            sw = r; hw = w;
        } BYTEORDER[22:22];

        field {
            desc = "If high, signifies that an ongoing transaction has stalled due
            to lack of available space in the RX FIFO.";
            sw = r; hw = w;
        } RXSTALL[23:23] = 1'b0;

        field {
            desc = "When high, indicates that the receive FIFO is empty. Any reads
            from RXDATA will cause an error interrupt.";
            sw = r; hw = w;
        } RXEMPTY[24:24] = 1'b0;

        field {
            desc = "When high, indicates that the receive FIFO is full. Any ongoing
            transactions will stall until firmware reads some data from RXDATA.";
            sw = r; hw = w;
        } RXFULL[25:25] = 1'b0;

        field {
            desc = "If high, the amount of data in the TX FIFO has fallen below the
            level of CONTROL.TX_WATERMARK words (32b each).";
            sw = r; hw = w;
        } TXWM[26:26] = 1'b0;

        field {
            desc = "If high, signifies that an ongoing transaction has stalled due
            to lack of data in the TX FIFO.";
            sw = r; hw = w;
        } TXSTALL[27:27] = 1'b0;

        field {
            desc = "When high, indicates that the transmit data FIFO is empty.";
            sw = r; hw = w;
        } TXEMPTY[28:28] = 1'b0;

        field {
            desc = "When high, indicates that the transmit data FIFO is full. Any
            further writes to TXDATA will create an error interrupt.";
            sw = r; hw = w;
        } TXFULL[29:29] = 1'b0;

        field {
            desc = "When high, indicates the SPI host is processing a previously
            issued command.";
            sw = r; hw = w;
        } ACTIVE[30:30] = 1'b0;

        field {
            desc = "When high, indicates the SPI host is ready to receive commands.
            Writing to COMMAND when READY is low is an error and will trigger an
            interrupt.";
            sw = r; hw = w;
        } READY[31:31] = 1'b0;

    } STATUS @ 0x10;

    reg {
        name = "Configuration Options";
        desc = "Configuration options register. One register per cs_n line (NumCS = 2).";

        field {
            desc = "Core clock divider. Slows down subsequent SPI transactions by a
            factor of (CLKDIV+1) relative to the core clock frequency. The period of
            sck, T(sck) then becomes 2*(CLKDIV+1)*T(core).";
            sw = rw; hw = r;
        } CLKDIV[15:0] = 16'h0000;

        field {
            desc = "Minimum idle time between commands. Indicates the minimum number
            of sck half-cycles to hold cs_n high between commands. Setting this
            register to zero creates a minimally-wide CS_N-high pulse of one-half
            sck cycle.";
            sw = rw; hw = r;
        } CSNIDLE[19:16] = 4'h0;

        field {
            desc = "CS_N Trailing Time. Indicates the number of half sck cycles,
            CSNTRAIL+1, to leave between the last edge of sck and the rising edge of
            cs_n. Setting this register to zero corresponds to the minimum delay of
            one-half sck cycle.";
            sw = rw; hw = r;
        } CSNTRAIL[23:20] = 4'h0;

        field {
            desc = "CS_N Leading Time. Indicates the number of half sck cycles,
            CSNLEAD+1, to leave between the falling edge of cs_n and the first edge
            of sck. Setting this register to zero corresponds to the minimum delay of
            one-half sck cycle.";
            sw = rw; hw = r;
        } CSNLEAD[27:24] = 4'h0;

        field {
            desc = "Full cycle. Modifies the CPHA sampling behavior to allow for
            longer device logic setup times. Rather than sampling the SD bus a half
            cycle after shifting out data, the data is sampled a full cycle after
            shifting data out.";
            sw = rw; hw = r;
        } FULLCYC[29:29] = 1'b0;

        field {
            desc = "The phase of the sck clock signal relative to the data. When
            CPHA = 0 the data changes on the trailing edge of sck and is typically
            sampled on the leading edge. When CPHA = 1 data lines change on the
            leading edge of sck and are typically sampled on the trailing edge.";
            sw = rw; hw = r;
        } CPHA[30:30] = 1'b0;

        field {
            desc = "The polarity of the sck clock signal. When CPOL is 0, sck is
            low when idle and emits high pulses. When CPOL is 1, sck is high when
            idle and emits a series of low pulses.";
            sw = rw; hw = r;
        } CPOL[31:31] = 1'b0;

    } CONFIGOPTS[2] @ 0x14 += 0x4;

    reg {
        name = "Chip-Select ID";
        desc = "Controls which device to target with the next command. This register
        is passed to the core whenever COMMAND is written. The core then asserts
        cio_csb_o[CSID] during execution of the command.";

        field {
            desc = "Chip Select ID";
            sw = rw; hw = r;
        } CSID[31:0] = 32'h00000000;

    } CSID @ 0x1C;

    reg {
        name = "Command Register";
        desc = "Parameters specific to each command segment. There is only one
        command register for controlling all attached SPI devices.";

        field {
            desc = "Segment Length. For read or write segments this field controls
            the number of 1-byte bursts to transmit and/or receive. For dummy
            segments (COMMAND.DIRECTION == 0) this controls the number of dummy
            cycles. The number of bytes (or dummy cycles) equals COMMAND.LEN + 1.";
            sw = w; hw = r; swwe;
        } LEN[8:0] = 9'h000;

        field {
            desc = "Chip Select Active After Transaction. If CSAAT = 0 the chip
            select line is raised immediately at the end of the command segment.
            If CSAAT = 1 the chip select line is left low, allowing multi-segment
            SPI transactions.";
            sw = w; hw = r; swwe;
        } CSAAT[9:9] = 1'b0;

        field {
            desc = "Speed for this command segment: 0 = Standard SPI, 1 = Dual SPI,
            2 = Quad SPI, 3 = RESERVED.";
            sw = w; hw = r; swwe;
        } SPEED[11:10] = 2'h0;

        field {
            desc = "Direction for this command: 0 = Dummy cycles (no TX/RX),
            1 = Rx only, 2 = Tx only, 3 = Bidirectional Tx/Rx (Standard SPI only).";
            sw = w; hw = r; swwe;
        } DIRECTION[13:12] = 2'h0;

    } COMMAND @ 0x20;

    reg {
        name = "SPI Receive Data";
        desc = "Reads from this register pull data from the RX FIFO. Individual
        bytes are always transmitted MSB first. If ByteOrder = 0 the first byte
        received is packed in the MSB of RXDATA; if ByteOrder = 1 the first byte
        received is packed into the LSB.";

        field {
            desc = "Receive data word read from the RX FIFO.";
            sw = r; hw = w;
        } RXDATA[31:0] = 32'h00000000;

    } RXDATA @ 0x24;

    reg {
        name = "SPI Transmit Data";
        desc = "Data written to this register is placed into the TX FIFO.
        Byte-enables are supported. If ByteOrder = 0 bits are transmitted in
        decreasing significance order (MSB first). If ByteOrder = 1 the byte
        order of multi-byte writes is reversed.";

        field {
            desc = "Transmit data word written into the TX FIFO.";
            sw = w; hw = r;
        } TXDATA[31:0] = 32'h00000000;

    } TXDATA @ 0x28;

    reg {
        name = "Error Enable";
        desc = "Controls which classes of errors raise an interrupt.";

        field {
            desc = "Command Error: if set, the block sends an error interrupt
            whenever a command is issued while busy (STATUS.READY is not asserted).";
            sw = rw; hw = r;
        } CMDBUSY[0:0] = 1'b1;

        field {
            desc = "Overflow Errors: if set, the block sends an error interrupt
            whenever the TX FIFO overflows.";
            sw = rw; hw = r;
        } OVERFLOW[1:1] = 1'b1;

        field {
            desc = "Underflow Errors: if set, the block sends an error interrupt
            whenever there is a read from RXDATA but the RX FIFO is empty.";
            sw = rw; hw = r;
        } UNDERFLOW[2:2] = 1'b1;

        field {
            desc = "Invalid Command Errors: if set, the block sends an error
            interrupt whenever a command is sent with invalid values for
            COMMAND.SPEED or COMMAND.DIRECTION.";
            sw = rw; hw = r;
        } CMDINVAL[3:3] = 1'b1;

        field {
            desc = "Invalid CSID: if set, the block sends an error interrupt
            whenever a command is submitted but CSID exceeds NumCS.";
            sw = rw; hw = r;
        } CSIDINVAL[4:4] = 1'b1;

    } ERROR_ENABLE @ 0x2C;

    reg {
        name = "Error Status";
        desc = "Indicates errors that have occurred. The corresponding bit must be
        cleared here before issuing any further commands.";

        field {
            desc = "Indicates a write to COMMAND when STATUS.READY = 0.";
            sw = rw; hw = rw; we; onwrite = woclr;
        } CMDBUSY[0:0] = 1'b0;

        field {
            desc = "Indicates that firmware has overflowed the TX FIFO.";
            sw = rw; hw = rw; we; onwrite = woclr;
        } OVERFLOW[1:1] = 1'b0;

        field {
            desc = "Indicates that firmware has attempted to read from RXDATA when
            the RX FIFO is empty.";
            sw = rw; hw = rw; we; onwrite = woclr;
        } UNDERFLOW[2:2] = 1'b0;

        field {
            desc = "Indicates an invalid command segment: either an invalid value of
            COMMAND.SPEED or a request for bidirectional data transfer at dual or
            quad speed.";
            sw = rw; hw = rw; we; onwrite = woclr;
        } CMDINVAL[3:3] = 1'b0;

        field {
            desc = "Indicates a command was attempted with an invalid value for CSID.";
            sw = rw; hw = rw; we; onwrite = woclr;
        } CSIDINVAL[4:4] = 1'b0;

        field {
            desc = "Indicates that TLUL attempted to write to TXDATA with no bytes
            enabled. Such zero-byte writes are not supported.";
            sw = rw; hw = rw; we; onwrite = woclr;
        } ACCESSINVAL[5:5] = 1'b0;

    } ERROR_STATUS @ 0x30;

    reg {
        name = "Event Enable";
        desc = "Controls which classes of SPI events raise an interrupt.";

        field {
            desc = "Assert to send a spi_event interrupt whenever STATUS.RXFULL
            goes high.";
            sw = rw; hw = r;
        } RXFULL[0:0] = 1'b0;

        field {
            desc = "Assert to send a spi_event interrupt whenever STATUS.TXEMPTY
            goes high.";
            sw = rw; hw = r;
        } TXEMPTY[1:1] = 1'b0;

        field {
            desc = "Assert to send a spi_event interrupt whenever the number of
            32-bit words in the RX FIFO is greater than CONTROL.RX_WATERMARK.
            To prevent reassertion, read more data from the RX FIFO or increase
            CONTROL.RX_WATERMARK.";
            sw = rw; hw = r;
        } RXWM[2:2] = 1'b0;

        field {
            desc = "Assert to send a spi_event interrupt whenever the number of
            32-bit words in the TX FIFO is less than CONTROL.TX_WATERMARK.
            To prevent reassertion, add more data to the TX FIFO or reduce
            CONTROL.TX_WATERMARK.";
            sw = rw; hw = r;
        } TXWM[3:3] = 1'b0;

        field {
            desc = "Assert to send a spi_event interrupt whenever STATUS.READY
            goes high.";
            sw = rw; hw = r;
        } READY[4:4] = 1'b0;

        field {
            desc = "Assert to send a spi_event interrupt whenever STATUS.ACTIVE
            goes low.";
            sw = rw; hw = r;
        } IDLE[5:5] = 1'b0;

    } EVENT_ENABLE @ 0x34;
};
