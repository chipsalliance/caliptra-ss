// SPDX-License-Identifier: Apache-2.0
//
// Licensed under the Apache License, Version 2.0 (the "License");
// you may not use this file except in compliance with the License.
// You may obtain a copy of the License at
//
// http://www.apache.org/licenses/LICENSE-2.0
//
// Unless required by applicable law or agreed to in writing, software
// distributed under the License is distributed on an "AS IS" BASIS,
// WITHOUT WARRANTIES OR CONDITIONS OF ANY KIND, either express or implied.
// See the License for the specific language governing permissions and
// limitations under the License.
//

property rd_swacc {
    component = field;
    type = boolean;
};

property wr_swacc {
    component = field;
    type = boolean;
};

regfile interface_regs {

    reg {
        field { sw=rw; hw=r; } value[32] = 32'b0;
    } generic_input_wires[2];

    reg {
        field { sw=r; hw=rw; } value[32] = 32'b0;
    } generic_output_wires[2];

    reg {
        default sw=rw;
        default hw=r;

        field {} value[32] = 32'b0;
    } cptra_obf_key[8];

    reg {
        field { sw=rw; hw=r; } cptra_pwrgood = 1'b0;
        field { sw=rw; hw=r; } cptra_ss_rst_b = 1'b0;

        // TODO: Revisit this
        //field { sw=rw; hw=r; } ss_debug_locked = 1'b0;
        //field { sw=rw; hw=r; } ss_device_lifecycle[2] = 2'b0;
        //field { sw=rw; hw=r; } scan_mode = 1'b0;

        field { sw=rw; hw=r; } force_mcu_dmi_core_enable = 1'b0;
        field { sw=rw; hw=r; } force_mcu_dmi_uncore_enable = 1'b0;

        field { sw=rw; hw=r; } bootfsm_brkpoint = 1'b0;
    } control;

    reg {
        field { sw=r; hw=rw; } cptra_error_fatal = 1'b0;
        field { sw=r; hw=rw; } cptra_error_non_fatal = 1'b0;

        field { sw=r; hw=rw; } ready_for_fuses = 1'b0;
        field { sw=r; hw=rw; } ready_for_fw_push = 1'b0;
        field { sw=r; hw=rw; } ready_for_runtime = 1'b0;

        field { sw=r; hw=rw; } mailbox_data_avail = 1'b0;
        field { sw=r; hw=rw; } mailbox_flow_done = 1'b0;
    } status;

    reg {
        default sw=rw;
        default hw=r;

        field {} pauser[32] = 32'b0;
    } pauser;

    reg {
        default sw=rw;
        default hw=r;

        field {} itrng_divisor[32] = 32'b0;
    } itrng_divisor;

    reg {
        default sw=r;
        default hw=rw;

        field {} cycle_count[32] = 32'b0;
    } cycle_count;

    reg {
        default sw=r;
        default hw=rw;

        field {} fpga_version[32] = 32'b0;
    } fpga_version;
    
    reg {
        default sw=rw;
        default hw=r;

        field {} lsu_user[32] = 32'b0;
    } lsu_user;
    reg {
        default sw=rw;
        default hw=r;

        field {} ifu_user[32] = 32'b0;
    } ifu_user;
    reg {
        default sw=rw;
        default hw=r;

        field {} clp_user[32] = 32'b0;
    } clp_user;
    reg {
        default sw=rw;
        default hw=r;

        field {} soc_config_user[32] = 32'b0;
    } soc_config_user;
    reg {
        default sw=rw;
        default hw=r;

        field {} sram_config_user[32] = 32'b0;
    } sram_config_user;
    reg {
        default sw=rw;
        default hw=r;

        field {} mcu_reset_vector[32] = 32'b0;
    } mcu_reset_vector;
    reg {
        field { sw=r; hw=rw; } mci_error_fatal = 1'b0;
        field { sw=r; hw=rw; } mci_error_non_fatal = 1'b0;
    } mci_error;
    reg {
        field { sw=rw; hw=r; } mcu_no_rom_config = 1'b0;
        field { sw=rw; hw=r; } cptra_ss_mci_boot_seq_brkpoint_i = 1'b0;
        field { sw=rw; hw=r; } cptra_ss_lc_Allow_RMA_on_PPD_i = 1'b0;
        field { sw=rw; hw=r; } cptra_ss_lc_ctrl_scan_rst_ni_i = 1'b0;
        field { sw=rw; hw=r; } cptra_ss_lc_esclate_scrap_state0_i = 1'b0;
        field { sw=rw; hw=r; } cptra_ss_lc_esclate_scrap_state1_i = 1'b0;
        
    } mcu_config;
    reg {
        field { sw=rw; hw=r; } value[32] = 32'b0;
    } mci_generic_input_wires[2];

    reg {
        field { sw=r; hw=rw; } value[32] = 32'b0;
    } mci_generic_output_wires[2];
};

regfile fifo_regs {
    reg {
        field { sw=r; hw=rw; rd_swacc=true; } next_char[8] = 8'b0;
        field { sw=r; hw=rw; } char_valid = 1'b0;
    } log_fifo_data;

    reg {
        field { sw=r; hw=rw; } log_fifo_empty = 1'b0;
        field { sw=r; hw=rw; } log_fifo_full = 1'b0;
    } log_fifo_status;

    reg {
        field { sw=rw; hw=r; wr_swacc=true; } itrng_data[32] = 32'b0;
    } itrng_fifo_data;
    
    reg {
        field { sw=r; hw=rw; } itrng_fifo_empty = 1'b0;
        field { sw=r; hw=rw; } itrng_fifo_full = 1'b0;
        field { sw=rw; hw=r; } itrng_fifo_reset = 1'b0;
    } itrng_fifo_status;
    
    reg {
        field { sw=r; hw=rw; rd_swacc=true; } out_data[32] = 32'b0;
    } dbg_fifo_pop;

    reg {
        field { sw=rw; hw=r; wr_swacc=true; } in_data[32] = 32'b0;
    } dbg_fifo_push;

    reg {
        field { sw=r; hw=rw; } dbg_fifo_empty = 1'b0;
        field { sw=r; hw=rw; } dbg_fifo_full = 1'b0;
    } dbg_fifo_status;
};

addrmap caliptra_fpga_realtime_regs {
    default regwidth = 32;
    default accesswidth = 32;

    interface_regs interface_regs @ 0x0000;
    fifo_regs fifo_regs @ 0x1000;
};
